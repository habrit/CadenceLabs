// Generated for: spectre
// Generated on: Feb 28 22:09:23 2023
// Design library name: Design
// Design cell name: NAND_schematic
// Design view name: schematic
simulator lang=spectre
global 0 vdd!
include "/home/ugrads/h/hbritton/cadence/models/spectre/tsmc20P.m"
include "/home/ugrads/h/hbritton/cadence/models/spectre/tsmc20N.m"

// Library name: Design
// Cell name: NAND
// View name: extracted
// View type: maskLayout
subckt NAND_extracted A B GND VDD Y
    \+3 (VDD B Y 8) tsmc20P w=6e-07 l=2e-07 as=1.8e-13 ad=3e-13 ps=6e-07 \
        pd=1.6e-06 m=1 region=sat
    \+2 (Y A VDD 8) tsmc20P w=6e-07 l=2e-07 as=3e-13 ad=1.8e-13 ps=1.6e-06 \
        pd=6e-07 m=1 region=sat
    \+1 (Y B 6 GND) tsmc20N w=3e-07 l=2e-07 as=1.1e-13 ad=1.9e-13 ps=7e-07 \
        pd=1.5e-06 m=1 region=sat
    \+0 (6 A GND GND) tsmc20N w=3e-07 l=2e-07 as=1.9e-13 ad=1.1e-13 \
        ps=1.5e-06 pd=7e-07 m=1 region=sat
ends NAND_extracted
// End of subcircuit definition.

// Library name: Design
// Cell name: NAND_schematic
// View name: schematic
I3 (inA inB 0 vdd! out) NAND_extracted
V0 (vdd! 0) vsource type=dc dc=1.8
C0 (out 0) capacitor c=50f m=1
V4 (inB 0) vsource type=pulse dc=1.8 val0=0 val1=1.8 period=12n delay=3n \
        rise=100p fall=100p width=5n
V3 (inA 0) vsource type=pulse dc=1.8 val0=0 val1=1.8 period=12n delay=3n \
        rise=100p fall=100p width=50n
simulatorOptions options psfversion="1.1.0" reltol=1e-3 vabstol=1e-6 \
    iabstol=1e-12 temp=27 tnom=27 scalem=1.0 scale=1.0 gmin=1e-12 rforce=1 \
    maxnotes=5 maxwarns=5 digits=5 cols=80 pivrel=1e-3 \
    sensfile="../psf/sens.output" checklimitdest=psf
tran tran stop=30n write="spectre.ic" writefinal="spectre.fc" \
    annotate=status maxiters=5
finalTimeOP info what=oppoint where=rawfile
modelParameter info what=models where=rawfile
element info what=inst where=rawfile
outputParameter info what=output where=rawfile
designParamVals info what=parameters where=rawfile
primitives info what=primitives where=rawfile
subckts info what=subckts where=rawfile
saveOptions options save=allpub
